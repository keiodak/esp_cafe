* TARPTERGE
.include models.lib
Vs pwr 0 9
Dp pwr vcc DMOD
XU1s13 n145 n10 n7 vcc 0 SW4066
XU1s5 n10 n127 n14 vcc 0 SW4066
XU1s6 n54 n3 n14 vcc 0 SW4066
XU1s12 n112 n3 n7 vcc 0 SW4066
XU2a n18 n17 n17 vcc 0 OPAMP
XU2b n6 n18 n85 vcc 0 OPAMP
XU3s13 n113 n27 n45 vcc 0 SW4066
XU3s5 n27 n88 n32 vcc 0 SW4066
XU3s6 n58 n41 n32 vcc 0 SW4066
XU3s12 n124 n41 n45 vcc 0 SW4066
XU4s13 n99 n18 n97 vcc 0 SW4066
XU4s5 n18 n101 n15 vcc 0 SW4066
XU4s6 n100 n6 n15 vcc 0 SW4066
XU4s12 n98 n6 n97 vcc 0 SW4066
XU5s13 n139 n33 n39 vcc 0 SW4066
XU5s5 n33 n56 n34 vcc 0 SW4066
XU5s6 n126 n43 n34 vcc 0 SW4066
XU5s12 n86 n43 n39 vcc 0 SW4066
XU6a n33 n42 n42 vcc 0 OPAMP
XU6b n43 n33 n78 vcc 0 OPAMP
XU7a n27 n31 n31 vcc 0 OPAMP
XU7b n41 n27 n87 vcc 0 OPAMP
XU8a n10 n4 n4 vcc 0 OPAMP
XU8b n3 n10 n134 vcc 0 OPAMP
Q1 n29 n82 n107 Q3906
Q2 n62 n63 0 Q3904
Q3 n68 n68 vcc Q3906
Q4 n16 n51 n89 Q3906
Q5 n90 n90 vcc Q3906
Q6 vcc n135 n140 Q3904
Q7 vcc n121 n80 Q3904
Q8 0 n135 n66 Q3906
Q9 n30 n30 0 Q3904
Q10 n29 n29 0 Q3904
Q11 0 n61 n60 Q3906
Q12 vcc n103 n114 Q3904
Q13 n67 n68 vcc Q3906
Q14 n19 n48 n66 Q3906
Q15 n81 n29 0 Q3904
Q16 n75 n76 0 Q3904
Q17 n115 n51 n114 Q3904
Q18 0 n103 n89 Q3906
Q19 n130 n129 vcc Q3906
Q20 n131 n94 vcc Q3906
Q21 0 n120 n119 Q3906
Q22 n68 n82 n138 Q3904
Q23 n55 n30 0 Q3904
Q24 0 n64 n65 Q3906
Q25 vcc n73 n93 Q3904
Q26 n108 n93 vcc Q3906
Q27 n147 n115 vcc Q3906
Q28 n105 n104 0 Q3904
Q29 0 n106 n107 Q3906
Q30 n118 n80 vcc Q3906
Q31 n132 n65 0 Q3904
Q32 0 n50 n104 Q3906
Q33 n137 n19 0 Q3904
Q34 n117 n60 0 Q3904
Q35 n94 n94 vcc Q3906
Q36 n102 n90 vcc Q3906
Q37 n70 n69 0 Q3904
Q38 n90 n48 n140 Q3904
Q39 n110 n77 0 Q3904
Q40 vcc n122 n129 Q3904
Q41 n142 n141 vcc Q3906
Q42 n79 n16 0 Q3904
Q43 n94 n95 n96 Q3904
Q44 n30 n95 n119 Q3906
Q45 n19 n19 0 Q3904
Q46 vcc n71 n141 Q3904
Q47 vcc n106 n138 Q3904
Q48 n16 n16 0 Q3904
Q49 vcc n120 n96 Q3904
Q50 n115 n115 vcc Q3906
Q51 0 n59 n74 Q3906
Q52 n91 n74 0 Q3904
R1 0 n50 10e3
C1 n0 n134 10n
R2 vcc n110 100e3
R3 n123 n122 470e3
R4 n44 n124 10e3
R5 n48 n9 100e3
R6 n44 n42 100e3
R7 n107 n108 4.7e3
R8 n71 vcc 10e3
R9 0 n111 22e3
R10 n2 n98 10e3
R11 n129 0 2.2e6
R12 n136 n50 470e3
R13 vcc n70 100e3
R14 n51 n20 100e3
R15 n75 vcc 100e3
R16 n91 n96 4.7e3
R17 n136 n73 470e3
R18 0 n61 10e3
R19 n17 n53 100e3
R20 n57 n120 10e3
R21 n37 n82 100e3
R22 n45 n87 100e3
R23 n60 vcc 2.2e6
R24 n138 n105 4.7e3
R25 n72 n71 470e3
R26 vcc n74 2.2e6
D1 n133 n75 DLED
R27 n13 n112 10e3
R28 vcc n144 4.7e3
R29 n143 n121 470e3
R31 n137 n101 4.7e3
R32 n103 n111 10e3
R33 n132 n140 4.7e3
R34 n80 0 2.2e6
R35 0 n47 22e3
R36 n52 vcc 4.7e3
R37 0 n141 2.2e6
R38 n135 n47 10e3
R39 n83 n82 10e3
R40 n113 n67 4.7e3
R41 n110 n34 100e3
R42 n70 n15 100e3
C2 n46 n78 10n
R43 n119 n130 4.7e3
R44 n35 n57 100e3
R45 n95 n57 10e3
D2 n62 n52 DLED
R46 n13 n31 100e3
R47 n111 n51 10e3
R48 n5 n11 100e3
C3 0 n128 10n
R49 n102 n99 4.7e3
R50 n83 n106 10e3
R51 n26 n25 100e3
R52 n125 n31 100e3
R53 n62 vcc 100e3
R54 n43 n78 2.2e6
R55 n24 n4 100e3
R56 n104 vcc 2.2e6
R57 n143 n61 470e3
R58 0 n64 10e3
R59 n54 n53 10e3
R60 n47 vcc 22e3
R61 vcc n57 22e3
R62 n133 vcc 4.7e3
R63 n72 n64 470e3
C4 n84 0 10n
C5 n38 n87 10n
R64 vcc n111 22e3
R65 n86 n35 10e3
R66 n79 n127 4.7e3
R67 n41 n87 2.2e6
R68 n125 n126 10e3
R69 n73 vcc 10e3
D3 n110 n144 DLED
R70 n100 n23 10e3
R71 n40 n37 100e3
R72 n55 n56 4.7e3
R73 n78 n39 100e3
R74 n25 n120 100e3
R75 n9 n5 100e3
R76 n62 n14 100e3
R77 n28 n26 100e3
R78 n88 n81 4.7e3
R79 n11 n135 100e3
R80 n21 n20 100e3
R81 n63 n134 100e3
R82 n4 n2 100e3
D4 n70 n151 DLED
R83 n59 n123 470e3
C6 n116 0 10n
R84 n87 n76 100e3
R85 n122 vcc 10e3
R86 n85 n1 100e3
R87 0 n83 22e3
R88 n3 n134 2.2e6
R89 n78 n77 100e3
R90 n69 n85 100e3
R91 vcc n83 22e3
R92 n121 vcc 10e3
C7 n8 n85 10n
R93 0 n59 10e3
R94 n147 n145 4.7e3
R95 n139 n131 4.7e3
R96 n85 n6 2.2e6
R97 n24 n58 10e3
R98 n95 n28 100e3
R99 n35 vcc 100e3
R100 n103 n22 100e3
R101 n57 n23 100e3
R102 n93 0 2.2e6
R104 vcc n65 2.2e6
R105 n117 n114 4.7e3
R106 n36 n106 100e3
R107 n32 n75 100e3
R108 n21 n22 100e3
R109 n118 n89 4.7e3
R110 n23 0 100e3
R111 n47 n48 10e3
R112 n7 n134 100e3
R113 n40 n36 100e3
C8 n148 0 10n
R114 n57 0 22e3
R115 vcc n151 4.7e3
R116 n142 n66 4.7e3
Vpot0 n123x 0 2.6999999999999997
Rpot0 n123x n123 25k
Vpot1 n136x 0 4.05
Rpot1 n136x n136 25k
Vpot2 n72x 0 5.3999999999999995
Rpot2 n72x n72 25k
Vpot3 n143x 0 6.75
Rpot3 n143x n143 25k
Rsw10 n10 n84 1
Rsw18 n18 n128 1
Rsw27 n27 n116 1
Rsw33 n33 n148 1
Rfix n97 n85 100k
.options method=gear reltol=2e-3 abstol=1e-10 vntol=1e-5 itl4=50
.tran 2u 20m uic
.control
run
wrdata /tmp/TARPTERGE.dat v(n18) v(n10) v(n27) v(n33)
wrdata /tmp/TARPTERGE.h1 v(n18) v(n85) v(n6) v(n90) v(n19) v(n97) v(n15) v(n2) v(n23) v(n17) v(n102) v(n137) v(n48) v(n47) v(n66) v(n140) v(n141) v(n65)
.endc
.end
